# Ansys Electronics Desktop project, version 2022.1
materials:
  vacuum: permittivity=1

design rect_lattice (HFSS, DrivenModal, model units mm)
geometry:
  Circ_Patch_5GHz1 = component(Circ_Patch_5GHz, 3D_Component_File_Path="C:/Users/asligar/OneDrive - ANSYS, Inc/Documents/Applications/AGI Demo/Circ_Patch_5GHz.a3dcomp", H=1.272mm, coax_inner_rad=0.25mm, Dp=23.53mm, Sx=35.29mm, Sy=35.29mm, Ln=1.502mm, Wn=3.004mm, beta2=-90deg, beta3=-180deg, beta4=-270deg, coax_outer_rad=0.85mm, feedLength=2.5mm, Sf=3.663mm, alpha=45deg, subWidth=80mm, subLength=80mm)
  Soil [Teflon (tm)] = part_of(Circ_Patch_5GHz1)
  Ground, Circle_2 [vacuum] = part_of(Circ_Patch_5GHz1)
  FeedPin_2, coax_pin_2 [pec] = part_of(Circ_Patch_5GHz1)
  coax_2 [Teflon (tm)] = part_of(Circ_Patch_5GHz1)
  Box1 [vacuum] = part_of(Circ_Patch_5GHz1)
  Circ_Patch_5GHz1.move(TranslateVectorX=0.24703 TranslateVectorY=0.24703 TranslateVectorZ=0)
boundaries and excitations:
  Circ_Patch_5GHz1_antennaMetal_2: Perfect E Objects=Circle_2
  Circ_Patch_5GHz1_groundMetal: Perfect E Objects=Ground
  Circ_Patch_5GHz1_coax_outer_2: Perfect E Faces=coax_2.face(#87)
  Circ_Patch_5GHz1_Rad1: Radiation Faces=Box1.face(#95)
  Circ_Patch_5GHz1_Primary1: Primary Faces=Box1.face(#99) CoordSysVector{(264.675, 264.675, -1.272) -> (264.675, 264.675, 30)}
  Circ_Patch_5GHz1_Secondary1: Secondary Faces=Box1.face(#97) CoordSysVector{(264.675, 229.385, -1.272) -> (264.675, 229.385, 30)} ReverseV primary=Circ_Patch_5GHz1_Primary1 PhaseDelay=UseScanAngle Phi=0deg Theta=0deg
  Circ_Patch_5GHz1_Primary2: Primary Faces=Box1.face(#100) CoordSysVector{(264.675, 229.385, -1.272) -> (264.675, 229.385, 30)}
  Circ_Patch_5GHz1_Secondary2: Secondary Faces=Box1.face(#98) CoordSysVector{(229.385, 229.385, -1.272) -> (229.385, 229.385, 30)} ReverseV primary=Circ_Patch_5GHz1_Primary2 PhaseDelay=UseScanAngle Phi=0deg Theta=0deg
  Circ_Patch_5GHz1_1: Wave Port Faces=coax_2.face(#88) NumModes=1 Modes{Mode1{IntLine{(243.83883, 243.83883, -3.772) -> (244.26309, 244.26309, -3.772)} CharImp=Zpi}}
array:
  Type="3D Component" Name=A UseAirObjects RowPrimaryBnd=Circ_Patch_5GHz1_Primary1 ColumnPrimaryBnd=Circ_Patch_5GHz1_Primary2 RowDimension=15 ColumnDimension=15 RenderType=0 Padding=0 ComponentList(5)
  UseAbove
source amplitudes:
  Circ_Patch_5GHz1_1:1: 1W 0deg
  Circ_Patch_5GHz1_1:2..Circ_Patch_5GHz1_1:225: 0W 0deg

design triangular_lattice (HFSS, DrivenModal, model units mm)
variables:
  ScanFrequency = 5000000000Hz
  ScanAngleTheta = 60deg
  ScanAnglePhi = 0deg
  ScanPhaseShiftA = -((ScanFrequency*-6.4447234425e-10*sin(ScanAngleTheta)*cos(ScanAnglePhi)) + (ScanFrequency*3.72086281438e-10*sin(ScanAngleTheta)*sin(ScanAnglePhi))) rad
  ScanPhaseShiftB = -((ScanFrequency*-6.4447234425e-10*sin(ScanAngleTheta)*cos(ScanAnglePhi)) + (ScanFrequency*-3.72086281438e-10*sin(ScanAngleTheta)*sin(ScanAnglePhi))) rad
  ScanMag1 = 1W
  ScanPhase1 = 0deg
geometry:
  Circ_Patch_5GHz_hex1 = component(Circ_Patch_5GHz_hex, 3D_Component_File_Path="C:/Users/asligar/OneDrive - ANSYS, Inc/Documents/Applications/AGI Demo/Circ_Patch_5GHz_hex.a3dcomp", H=1.272mm, coax_inner_rad=0.25mm, Dp=23.53mm, Sx=35.29mm, Sy=35.29mm, Ln=1.502mm, Wn=3.004mm, beta3=-180deg, coax_outer_rad=0.85mm, feedLength=2.5mm, Sf=3.663mm, alpha=45deg)
  Circle_2 [vacuum] = part_of(Circ_Patch_5GHz_hex1)
  FeedPin_2, coax_pin_2 [pec] = part_of(Circ_Patch_5GHz_hex1)
  coax_2 [Teflon (tm)] = part_of(Circ_Patch_5GHz_hex1)
  Cylinder1 [vacuum] = part_of(Circ_Patch_5GHz_hex1)
  sub, sub_ObjectFromFace1 [Teflon (tm)] = part_of(Circ_Patch_5GHz_hex1)
  Circ_Patch_5GHz_hex1.move(TranslateVectorX=0.21525 TranslateVectorY=-0.12427465 TranslateVectorZ=0)
boundaries and excitations:
  Circ_Patch_5GHz_hex1_antennaMetal_2: Perfect E Objects=Circle_2
  Circ_Patch_5GHz_hex1_coax_outer_2: Perfect E Faces=coax_2.face(#48)
  Circ_Patch_5GHz_hex1_PerfE1: Perfect E Objects=sub_ObjectFromFace1
  Circ_Patch_5GHz_hex1_Rad1: Radiation Faces=Cylinder1.face(#56)
  Circ_Patch_5GHz_hex1_Primary1: Primary Faces=Cylinder1.face(#58) CoordSysVector{(225.5, -142.02817, -1.272) -> (225.5, -142.02817, 38.728)}
  Circ_Patch_5GHz_hex1_Secondary1: Secondary Faces=Cylinder1.face(#61) CoordSysVector{(194.75, -124.27465, -1.272) -> (194.75, -124.27465, 38.728)} ReverseV primary=Circ_Patch_5GHz_hex1_Primary1 PhaseDelay=UseScanAngle Phi=0deg Theta=0deg
  Circ_Patch_5GHz_hex1_Primary2: Primary Faces=Cylinder1.face(#63) CoordSysVector{(235.75, -124.27465, -1.272) -> (235.75, -124.27465, 38.728)}
  Circ_Patch_5GHz_hex1_Secondary2: Secondary Faces=Cylinder1.face(#60) CoordSysVector{(205, -142.02817, -1.272) -> (205, -142.02817, 38.728)} ReverseV primary=Circ_Patch_5GHz_hex1_Primary2 PhaseDelay=UseScanAngle Phi=0deg Theta=0deg
  Circ_Patch_5GHz_hex1_Primary3: Primary Faces=Cylinder1.face(#62) CoordSysVector{(225.5, -106.52112, -1.272) -> (225.5, -106.52112, 38.728)}
  Circ_Patch_5GHz_hex1_Secondary3: Secondary Faces=Cylinder1.face(#59) CoordSysVector{(225.5, -142.02817, -1.272) -> (225.5, -142.02817, 38.728)} ReverseV primary=Circ_Patch_5GHz_hex1_Primary3 PhaseDelay=UseScanAngle Phi=0deg Theta=0deg
  Circ_Patch_5GHz_hex1_1: Wave Port Faces=coax_2.face(#49) NumModes=1 Modes{Mode1{IntLine{(212.05883, -127.46582, -3.772) -> (212.48309, -127.04155, -3.772)} CharImp=Zpi}}
array:
  Type="3D Component" Name=A UseAirObjects RowPrimaryBnd=Circ_Patch_5GHz_hex1_Primary1 ColumnPrimaryBnd=Circ_Patch_5GHz_hex1_Primary2 RowDimension=15 ColumnDimension=15 RenderType=0 Padding=0 ComponentList(5)
  UseAbove
setups:
  Setup1: HfssDriven Frequency=5GHz MaxDeltaS=0.02 MaximumPasses=3 MinimumPasses=1 MinimumConvergedPasses=1 PercentRefinement=30 BasisOrder=1 PortAccuracy=2 DrivenSolverType="Direct Solver" SaveRadFieldsOnly InfiniteSphereSetup=1
source amplitudes:
  Circ_Patch_5GHz_hex1_1:1: ScanMag1*1 ScanPhase1 + (0*ScanPhaseShiftA + 7*ScanPhaseShiftB)
  Circ_Patch_5GHz_hex1_1:2: ScanMag1*1 ScanPhase1 + (0*ScanPhaseShiftA + 8*ScanPhaseShiftB)
  Circ_Patch_5GHz_hex1_1:3: ScanMag1*1 ScanPhase1 + (0*ScanPhaseShiftA + 9*ScanPhaseShiftB)
  Circ_Patch_5GHz_hex1_1:4: ScanMag1*1 ScanPhase1 + (0*ScanPhaseShiftA + 10*ScanPhaseShiftB)
  Circ_Patch_5GHz_hex1_1:5: ScanMag1*1 ScanPhase1 + (0*ScanPhaseShiftA + 11*ScanPhaseShiftB)
  Circ_Patch_5GHz_hex1_1:6: ScanMag1*1 ScanPhase1 + (0*ScanPhaseShiftA + 12*ScanPhaseShiftB)
  Circ_Patch_5GHz_hex1_1:7: ScanMag1*1 ScanPhase1 + (0*ScanPhaseShiftA + 13*ScanPhaseShiftB)
  Circ_Patch_5GHz_hex1_1:8: ScanMag1*1 ScanPhase1 + (0*ScanPhaseShiftA + 14*ScanPhaseShiftB)
  Circ_Patch_5GHz_hex1_1:9: ScanMag1*1 ScanPhase1 + (1*ScanPhaseShiftA + 6*ScanPhaseShiftB)
  Circ_Patch_5GHz_hex1_1:10: ScanMag1*1 ScanPhase1 + (1*ScanPhaseShiftA + 7*ScanPhaseShiftB)
  Circ_Patch_5GHz_hex1_1:11: ScanMag1*1 ScanPhase1 + (1*ScanPhaseShiftA + 8*ScanPhaseShiftB)
  Circ_Patch_5GHz_hex1_1:12: ScanMag1*1 ScanPhase1 + (1*ScanPhaseShiftA + 9*ScanPhaseShiftB)
  Circ_Patch_5GHz_hex1_1:13: ScanMag1*1 ScanPhase1 + (1*ScanPhaseShiftA + 10*ScanPhaseShiftB)
  Circ_Patch_5GHz_hex1_1:14: ScanMag1*1 ScanPhase1 + (1*ScanPhaseShiftA + 11*ScanPhaseShiftB)
  Circ_Patch_5GHz_hex1_1:15: ScanMag1*1 ScanPhase1 + (1*ScanPhaseShiftA + 12*ScanPhaseShiftB)
  Circ_Patch_5GHz_hex1_1:16: ScanMag1*1 ScanPhase1 + (1*ScanPhaseShiftA + 13*ScanPhaseShiftB)
  Circ_Patch_5GHz_hex1_1:17: ScanMag1*1 ScanPhase1 + (1*ScanPhaseShiftA + 14*ScanPhaseShiftB)
  Circ_Patch_5GHz_hex1_1:18: ScanMag1*1 ScanPhase1 + (2*ScanPhaseShiftA + 5*ScanPhaseShiftB)
  Circ_Patch_5GHz_hex1_1:19: ScanMag1*1 ScanPhase1 + (2*ScanPhaseShiftA + 6*ScanPhaseShiftB)
  Circ_Patch_5GHz_hex1_1:20: ScanMag1*1 ScanPhase1 + (2*ScanPhaseShiftA + 7*ScanPhaseShiftB)
  Circ_Patch_5GHz_hex1_1:21: ScanMag1*1 ScanPhase1 + (2*ScanPhaseShiftA + 8*ScanPhaseShiftB)
  Circ_Patch_5GHz_hex1_1:22: ScanMag1*1 ScanPhase1 + (2*ScanPhaseShiftA + 9*ScanPhaseShiftB)
  Circ_Patch_5GHz_hex1_1:23: ScanMag1*1 ScanPhase1 + (2*ScanPhaseShiftA + 10*ScanPhaseShiftB)
  Circ_Patch_5GHz_hex1_1:24: ScanMag1*1 ScanPhase1 + (2*ScanPhaseShiftA + 11*ScanPhaseShiftB)
  Circ_Patch_5GHz_hex1_1:25: ScanMag1*1 ScanPhase1 + (2*ScanPhaseShiftA + 12*ScanPhaseShiftB)
  Circ_Patch_5GHz_hex1_1:26: ScanMag1*1 ScanPhase1 + (2*ScanPhaseShiftA + 13*ScanPhaseShiftB)
  Circ_Patch_5GHz_hex1_1:27: ScanMag1*1 ScanPhase1 + (2*ScanPhaseShiftA + 14*ScanPhaseShiftB)
  Circ_Patch_5GHz_hex1_1:28: ScanMag1*1 ScanPhase1 + (3*ScanPhaseShiftA + 4*ScanPhaseShiftB)
  Circ_Patch_5GHz_hex1_1:29: ScanMag1*1 ScanPhase1 + (3*ScanPhaseShiftA + 5*ScanPhaseShiftB)
  Circ_Patch_5GHz_hex1_1:30: ScanMag1*1 ScanPhase1 + (3*ScanPhaseShiftA + 6*ScanPhaseShiftB)
  Circ_Patch_5GHz_hex1_1:31: ScanMag1*1 ScanPhase1 + (3*ScanPhaseShiftA + 7*ScanPhaseShiftB)
  Circ_Patch_5GHz_hex1_1:32: ScanMag1*1 ScanPhase1 + (3*ScanPhaseShiftA + 8*ScanPhaseShiftB)
  Circ_Patch_5GHz_hex1_1:33: ScanMag1*1 ScanPhase1 + (3*ScanPhaseShiftA + 9*ScanPhaseShiftB)
  Circ_Patch_5GHz_hex1_1:34: ScanMag1*1 ScanPhase1 + (3*ScanPhaseShiftA + 10*ScanPhaseShiftB)
  Circ_Patch_5GHz_hex1_1:35: ScanMag1*1 ScanPhase1 + (3*ScanPhaseShiftA + 11*ScanPhaseShiftB)
  Circ_Patch_5GHz_hex1_1:36: ScanMag1*1 ScanPhase1 + (3*ScanPhaseShiftA + 12*ScanPhaseShiftB)
  Circ_Patch_5GHz_hex1_1:37: ScanMag1*1 ScanPhase1 + (3*ScanPhaseShiftA + 13*ScanPhaseShiftB)
  Circ_Patch_5GHz_hex1_1:38: ScanMag1*1 ScanPhase1 + (3*ScanPhaseShiftA + 14*ScanPhaseShiftB)
  Circ_Patch_5GHz_hex1_1:39: ScanMag1*1 ScanPhase1 + (4*ScanPhaseShiftA + 3*ScanPhaseShiftB)
  Circ_Patch_5GHz_hex1_1:40: ScanMag1*1 ScanPhase1 + (4*ScanPhaseShiftA + 4*ScanPhaseShiftB)
  Circ_Patch_5GHz_hex1_1:41: ScanMag1*1 ScanPhase1 + (4*ScanPhaseShiftA + 5*ScanPhaseShiftB)
  Circ_Patch_5GHz_hex1_1:42: ScanMag1*1 ScanPhase1 + (4*ScanPhaseShiftA + 6*ScanPhaseShiftB)
  Circ_Patch_5GHz_hex1_1:43: ScanMag1*1 ScanPhase1 + (4*ScanPhaseShiftA + 7*ScanPhaseShiftB)
  Circ_Patch_5GHz_hex1_1:44: ScanMag1*1 ScanPhase1 + (4*ScanPhaseShiftA + 8*ScanPhaseShiftB)
  Circ_Patch_5GHz_hex1_1:45: ScanMag1*1 ScanPhase1 + (4*ScanPhaseShiftA + 9*ScanPhaseShiftB)
  Circ_Patch_5GHz_hex1_1:46: ScanMag1*1 ScanPhase1 + (4*ScanPhaseShiftA + 10*ScanPhaseShiftB)
  Circ_Patch_5GHz_hex1_1:47: ScanMag1*1 ScanPhase1 + (4*ScanPhaseShiftA + 11*ScanPhaseShiftB)
  Circ_Patch_5GHz_hex1_1:48: ScanMag1*1 ScanPhase1 + (4*ScanPhaseShiftA + 12*ScanPhaseShiftB)
  Circ_Patch_5GHz_hex1_1:49: ScanMag1*1 ScanPhase1 + (4*ScanPhaseShiftA + 13*ScanPhaseShiftB)
  Circ_Patch_5GHz_hex1_1:50: ScanMag1*1 ScanPhase1 + (4*ScanPhaseShiftA + 14*ScanPhaseShiftB)
  Circ_Patch_5GHz_hex1_1:51: ScanMag1*1 ScanPhase1 + (5*ScanPhaseShiftA + 2*ScanPhaseShiftB)
  Circ_Patch_5GHz_hex1_1:52: ScanMag1*1 ScanPhase1 + (5*ScanPhaseShiftA + 3*ScanPhaseShiftB)
  Circ_Patch_5GHz_hex1_1:53: ScanMag1*1 ScanPhase1 + (5*ScanPhaseShiftA + 4*ScanPhaseShiftB)
  Circ_Patch_5GHz_hex1_1:54: ScanMag1*1 ScanPhase1 + (5*ScanPhaseShiftA + 5*ScanPhaseShiftB)
  Circ_Patch_5GHz_hex1_1:55: ScanMag1*1 ScanPhase1 + (5*ScanPhaseShiftA + 6*ScanPhaseShiftB)
  Circ_Patch_5GHz_hex1_1:56: ScanMag1*1 ScanPhase1 + (5*ScanPhaseShiftA + 7*ScanPhaseShiftB)
  Circ_Patch_5GHz_hex1_1:57: ScanMag1*1 ScanPhase1 + (5*ScanPhaseShiftA + 8*ScanPhaseShiftB)
  Circ_Patch_5GHz_hex1_1:58: ScanMag1*1 ScanPhase1 + (5*ScanPhaseShiftA + 9*ScanPhaseShiftB)
  Circ_Patch_5GHz_hex1_1:59: ScanMag1*1 ScanPhase1 + (5*ScanPhaseShiftA + 10*ScanPhaseShiftB)
  Circ_Patch_5GHz_hex1_1:60: ScanMag1*1 ScanPhase1 + (5*ScanPhaseShiftA + 11*ScanPhaseShiftB)
  Circ_Patch_5GHz_hex1_1:61: ScanMag1*1 ScanPhase1 + (5*ScanPhaseShiftA + 12*ScanPhaseShiftB)
  Circ_Patch_5GHz_hex1_1:62: ScanMag1*1 ScanPhase1 + (5*ScanPhaseShiftA + 13*ScanPhaseShiftB)
  Circ_Patch_5GHz_hex1_1:63: ScanMag1*1 ScanPhase1 + (5*ScanPhaseShiftA + 14*ScanPhaseShiftB)
  Circ_Patch_5GHz_hex1_1:64: ScanMag1*1 ScanPhase1 + (6*ScanPhaseShiftA + 1*ScanPhaseShiftB)
  Circ_Patch_5GHz_hex1_1:65: ScanMag1*1 ScanPhase1 + (6*ScanPhaseShiftA + 2*ScanPhaseShiftB)
  Circ_Patch_5GHz_hex1_1:66: ScanMag1*1 ScanPhase1 + (6*ScanPhaseShiftA + 3*ScanPhaseShiftB)
  Circ_Patch_5GHz_hex1_1:67: ScanMag1*1 ScanPhase1 + (6*ScanPhaseShiftA + 4*ScanPhaseShiftB)
  Circ_Patch_5GHz_hex1_1:68: ScanMag1*1 ScanPhase1 + (6*ScanPhaseShiftA + 5*ScanPhaseShiftB)
  Circ_Patch_5GHz_hex1_1:69: ScanMag1*1 ScanPhase1 + (6*ScanPhaseShiftA + 6*ScanPhaseShiftB)
  Circ_Patch_5GHz_hex1_1:70: ScanMag1*1 ScanPhase1 + (6*ScanPhaseShiftA + 7*ScanPhaseShiftB)
  Circ_Patch_5GHz_hex1_1:71: ScanMag1*1 ScanPhase1 + (6*ScanPhaseShiftA + 8*ScanPhaseShiftB)
  Circ_Patch_5GHz_hex1_1:72: ScanMag1*1 ScanPhase1 + (6*ScanPhaseShiftA + 9*ScanPhaseShiftB)
  Circ_Patch_5GHz_hex1_1:73: ScanMag1*1 ScanPhase1 + (6*ScanPhaseShiftA + 10*ScanPhaseShiftB)
  Circ_Patch_5GHz_hex1_1:74: ScanMag1*1 ScanPhase1 + (6*ScanPhaseShiftA + 11*ScanPhaseShiftB)
  Circ_Patch_5GHz_hex1_1:75: ScanMag1*1 ScanPhase1 + (6*ScanPhaseShiftA + 12*ScanPhaseShiftB)
  Circ_Patch_5GHz_hex1_1:76: ScanMag1*1 ScanPhase1 + (6*ScanPhaseShiftA + 13*ScanPhaseShiftB)
  Circ_Patch_5GHz_hex1_1:77: ScanMag1*1 ScanPhase1 + (6*ScanPhaseShiftA + 14*ScanPhaseShiftB)
  Circ_Patch_5GHz_hex1_1:78: ScanMag1*1 ScanPhase1 + (7*ScanPhaseShiftA + 0*ScanPhaseShiftB)
  Circ_Patch_5GHz_hex1_1:79: ScanMag1*1 ScanPhase1 + (7*ScanPhaseShiftA + 1*ScanPhaseShiftB)
  Circ_Patch_5GHz_hex1_1:80: ScanMag1*1 ScanPhase1 + (7*ScanPhaseShiftA + 2*ScanPhaseShiftB)
  Circ_Patch_5GHz_hex1_1:81: ScanMag1*1 ScanPhase1 + (7*ScanPhaseShiftA + 3*ScanPhaseShiftB)
  Circ_Patch_5GHz_hex1_1:82: ScanMag1*1 ScanPhase1 + (7*ScanPhaseShiftA + 4*ScanPhaseShiftB)
  Circ_Patch_5GHz_hex1_1:83: ScanMag1*1 ScanPhase1 + (7*ScanPhaseShiftA + 5*ScanPhaseShiftB)
  Circ_Patch_5GHz_hex1_1:84: ScanMag1*1 ScanPhase1 + (7*ScanPhaseShiftA + 6*ScanPhaseShiftB)
  Circ_Patch_5GHz_hex1_1:85: ScanMag1*1 ScanPhase1 + (7*ScanPhaseShiftA + 7*ScanPhaseShiftB)
  Circ_Patch_5GHz_hex1_1:86: ScanMag1*1 ScanPhase1 + (7*ScanPhaseShiftA + 8*ScanPhaseShiftB)
  Circ_Patch_5GHz_hex1_1:87: ScanMag1*1 ScanPhase1 + (7*ScanPhaseShiftA + 9*ScanPhaseShiftB)
  Circ_Patch_5GHz_hex1_1:88: ScanMag1*1 ScanPhase1 + (7*ScanPhaseShiftA + 10*ScanPhaseShiftB)
  Circ_Patch_5GHz_hex1_1:89: ScanMag1*1 ScanPhase1 + (7*ScanPhaseShiftA + 11*ScanPhaseShiftB)
  Circ_Patch_5GHz_hex1_1:90: ScanMag1*1 ScanPhase1 + (7*ScanPhaseShiftA + 12*ScanPhaseShiftB)
  Circ_Patch_5GHz_hex1_1:91: ScanMag1*1 ScanPhase1 + (7*ScanPhaseShiftA + 13*ScanPhaseShiftB)
  Circ_Patch_5GHz_hex1_1:92: ScanMag1*1 ScanPhase1 + (7*ScanPhaseShiftA + 14*ScanPhaseShiftB)
  Circ_Patch_5GHz_hex1_1:93: ScanMag1*1 ScanPhase1 + (8*ScanPhaseShiftA + 0*ScanPhaseShiftB)
  Circ_Patch_5GHz_hex1_1:94: ScanMag1*1 ScanPhase1 + (8*ScanPhaseShiftA + 1*ScanPhaseShiftB)
  Circ_Patch_5GHz_hex1_1:95: ScanMag1*1 ScanPhase1 + (8*ScanPhaseShiftA + 2*ScanPhaseShiftB)
  Circ_Patch_5GHz_hex1_1:96: ScanMag1*1 ScanPhase1 + (8*ScanPhaseShiftA + 3*ScanPhaseShiftB)
  Circ_Patch_5GHz_hex1_1:97: ScanMag1*1 ScanPhase1 + (8*ScanPhaseShiftA + 4*ScanPhaseShiftB)
  Circ_Patch_5GHz_hex1_1:98: ScanMag1*1 ScanPhase1 + (8*ScanPhaseShiftA + 5*ScanPhaseShiftB)
  Circ_Patch_5GHz_hex1_1:99: ScanMag1*1 ScanPhase1 + (8*ScanPhaseShiftA + 6*ScanPhaseShiftB)
  Circ_Patch_5GHz_hex1_1:100: ScanMag1*1 ScanPhase1 + (8*ScanPhaseShiftA + 7*ScanPhaseShiftB)
  Circ_Patch_5GHz_hex1_1:101: ScanMag1*1 ScanPhase1 + (8*ScanPhaseShiftA + 8*ScanPhaseShiftB)
  Circ_Patch_5GHz_hex1_1:102: ScanMag1*1 ScanPhase1 + (8*ScanPhaseShiftA + 9*ScanPhaseShiftB)
  Circ_Patch_5GHz_hex1_1:103: ScanMag1*1 ScanPhase1 + (8*ScanPhaseShiftA + 10*ScanPhaseShiftB)
  Circ_Patch_5GHz_hex1_1:104: ScanMag1*1 ScanPhase1 + (8*ScanPhaseShiftA + 11*ScanPhaseShiftB)
  Circ_Patch_5GHz_hex1_1:105: ScanMag1*1 ScanPhase1 + (8*ScanPhaseShiftA + 12*ScanPhaseShiftB)
  Circ_Patch_5GHz_hex1_1:106: ScanMag1*1 ScanPhase1 + (8*ScanPhaseShiftA + 13*ScanPhaseShiftB)
  Circ_Patch_5GHz_hex1_1:107: ScanMag1*1 ScanPhase1 + (9*ScanPhaseShiftA + 0*ScanPhaseShiftB)
  Circ_Patch_5GHz_hex1_1:108: ScanMag1*1 ScanPhase1 + (9*ScanPhaseShiftA + 1*ScanPhaseShiftB)
  Circ_Patch_5GHz_hex1_1:109: ScanMag1*1 ScanPhase1 + (9*ScanPhaseShiftA + 2*ScanPhaseShiftB)
  Circ_Patch_5GHz_hex1_1:110: ScanMag1*1 ScanPhase1 + (9*ScanPhaseShiftA + 3*ScanPhaseShiftB)
  Circ_Patch_5GHz_hex1_1:111: ScanMag1*1 ScanPhase1 + (9*ScanPhaseShiftA + 4*ScanPhaseShiftB)
  Circ_Patch_5GHz_hex1_1:112: ScanMag1*1 ScanPhase1 + (9*ScanPhaseShiftA + 5*ScanPhaseShiftB)
  Circ_Patch_5GHz_hex1_1:113: ScanMag1*1 ScanPhase1 + (9*ScanPhaseShiftA + 6*ScanPhaseShiftB)
  Circ_Patch_5GHz_hex1_1:114: ScanMag1*1 ScanPhase1 + (9*ScanPhaseShiftA + 7*ScanPhaseShiftB)
  Circ_Patch_5GHz_hex1_1:115: ScanMag1*1 ScanPhase1 + (9*ScanPhaseShiftA + 8*ScanPhaseShiftB)
  Circ_Patch_5GHz_hex1_1:116: ScanMag1*1 ScanPhase1 + (9*ScanPhaseShiftA + 9*ScanPhaseShiftB)
  Circ_Patch_5GHz_hex1_1:117: ScanMag1*1 ScanPhase1 + (9*ScanPhaseShiftA + 10*ScanPhaseShiftB)
  Circ_Patch_5GHz_hex1_1:118: ScanMag1*1 ScanPhase1 + (9*ScanPhaseShiftA + 11*ScanPhaseShiftB)
  Circ_Patch_5GHz_hex1_1:119: ScanMag1*1 ScanPhase1 + (9*ScanPhaseShiftA + 12*ScanPhaseShiftB)
  Circ_Patch_5GHz_hex1_1:120: ScanMag1*1 ScanPhase1 + (10*ScanPhaseShiftA + 0*ScanPhaseShiftB)
  Circ_Patch_5GHz_hex1_1:121: ScanMag1*1 ScanPhase1 + (10*ScanPhaseShiftA + 1*ScanPhaseShiftB)
  Circ_Patch_5GHz_hex1_1:122: ScanMag1*1 ScanPhase1 + (10*ScanPhaseShiftA + 2*ScanPhaseShiftB)
  Circ_Patch_5GHz_hex1_1:123: ScanMag1*1 ScanPhase1 + (10*ScanPhaseShiftA + 3*ScanPhaseShiftB)
  Circ_Patch_5GHz_hex1_1:124: ScanMag1*1 ScanPhase1 + (10*ScanPhaseShiftA + 4*ScanPhaseShiftB)
  Circ_Patch_5GHz_hex1_1:125: ScanMag1*1 ScanPhase1 + (10*ScanPhaseShiftA + 5*ScanPhaseShiftB)
  Circ_Patch_5GHz_hex1_1:126: ScanMag1*1 ScanPhase1 + (10*ScanPhaseShiftA + 6*ScanPhaseShiftB)
  Circ_Patch_5GHz_hex1_1:127: ScanMag1*1 ScanPhase1 + (10*ScanPhaseShiftA + 7*ScanPhaseShiftB)
  Circ_Patch_5GHz_hex1_1:128: ScanMag1*1 ScanPhase1 + (10*ScanPhaseShiftA + 8*ScanPhaseShiftB)
  Circ_Patch_5GHz_hex1_1:129: ScanMag1*1 ScanPhase1 + (10*ScanPhaseShiftA + 9*ScanPhaseShiftB)
  Circ_Patch_5GHz_hex1_1:130: ScanMag1*1 ScanPhase1 + (10*ScanPhaseShiftA + 10*ScanPhaseShiftB)
  Circ_Patch_5GHz_hex1_1:131: ScanMag1*1 ScanPhase1 + (10*ScanPhaseShiftA + 11*ScanPhaseShiftB)
  Circ_Patch_5GHz_hex1_1:132: ScanMag1*1 ScanPhase1 + (11*ScanPhaseShiftA + 0*ScanPhaseShiftB)
  Circ_Patch_5GHz_hex1_1:133: ScanMag1*1 ScanPhase1 + (11*ScanPhaseShiftA + 1*ScanPhaseShiftB)
  Circ_Patch_5GHz_hex1_1:134: ScanMag1*1 ScanPhase1 + (11*ScanPhaseShiftA + 2*ScanPhaseShiftB)
  Circ_Patch_5GHz_hex1_1:135: ScanMag1*1 ScanPhase1 + (11*ScanPhaseShiftA + 3*ScanPhaseShiftB)
  Circ_Patch_5GHz_hex1_1:136: ScanMag1*1 ScanPhase1 + (11*ScanPhaseShiftA + 4*ScanPhaseShiftB)
  Circ_Patch_5GHz_hex1_1:137: ScanMag1*1 ScanPhase1 + (11*ScanPhaseShiftA + 5*ScanPhaseShiftB)
  Circ_Patch_5GHz_hex1_1:138: ScanMag1*1 ScanPhase1 + (11*ScanPhaseShiftA + 6*ScanPhaseShiftB)
  Circ_Patch_5GHz_hex1_1:139: ScanMag1*1 ScanPhase1 + (11*ScanPhaseShiftA + 7*ScanPhaseShiftB)
  Circ_Patch_5GHz_hex1_1:140: ScanMag1*1 ScanPhase1 + (11*ScanPhaseShiftA + 8*ScanPhaseShiftB)
  Circ_Patch_5GHz_hex1_1:141: ScanMag1*1 ScanPhase1 + (11*ScanPhaseShiftA + 9*ScanPhaseShiftB)
  Circ_Patch_5GHz_hex1_1:142: ScanMag1*1 ScanPhase1 + (11*ScanPhaseShiftA + 10*ScanPhaseShiftB)
  Circ_Patch_5GHz_hex1_1:143: ScanMag1*1 ScanPhase1 + (12*ScanPhaseShiftA + 0*ScanPhaseShiftB)
  Circ_Patch_5GHz_hex1_1:144: ScanMag1*1 ScanPhase1 + (12*ScanPhaseShiftA + 1*ScanPhaseShiftB)
  Circ_Patch_5GHz_hex1_1:145: ScanMag1*1 ScanPhase1 + (12*ScanPhaseShiftA + 2*ScanPhaseShiftB)
  Circ_Patch_5GHz_hex1_1:146: ScanMag1*1 ScanPhase1 + (12*ScanPhaseShiftA + 3*ScanPhaseShiftB)
  Circ_Patch_5GHz_hex1_1:147: ScanMag1*1 ScanPhase1 + (12*ScanPhaseShiftA + 4*ScanPhaseShiftB)
  Circ_Patch_5GHz_hex1_1:148: ScanMag1*1 ScanPhase1 + (12*ScanPhaseShiftA + 5*ScanPhaseShiftB)
  Circ_Patch_5GHz_hex1_1:149: ScanMag1*1 ScanPhase1 + (12*ScanPhaseShiftA + 6*ScanPhaseShiftB)
  Circ_Patch_5GHz_hex1_1:150: ScanMag1*1 ScanPhase1 + (12*ScanPhaseShiftA + 7*ScanPhaseShiftB)
  Circ_Patch_5GHz_hex1_1:151: ScanMag1*1 ScanPhase1 + (12*ScanPhaseShiftA + 8*ScanPhaseShiftB)
  Circ_Patch_5GHz_hex1_1:152: ScanMag1*1 ScanPhase1 + (12*ScanPhaseShiftA + 9*ScanPhaseShiftB)
  Circ_Patch_5GHz_hex1_1:153: ScanMag1*1 ScanPhase1 + (13*ScanPhaseShiftA + 0*ScanPhaseShiftB)
  Circ_Patch_5GHz_hex1_1:154: ScanMag1*1 ScanPhase1 + (13*ScanPhaseShiftA + 1*ScanPhaseShiftB)
  Circ_Patch_5GHz_hex1_1:155: ScanMag1*1 ScanPhase1 + (13*ScanPhaseShiftA + 2*ScanPhaseShiftB)
  Circ_Patch_5GHz_hex1_1:156: ScanMag1*1 ScanPhase1 + (13*ScanPhaseShiftA + 3*ScanPhaseShiftB)
  Circ_Patch_5GHz_hex1_1:157: ScanMag1*1 ScanPhase1 + (13*ScanPhaseShiftA + 4*ScanPhaseShiftB)
  Circ_Patch_5GHz_hex1_1:158: ScanMag1*1 ScanPhase1 + (13*ScanPhaseShiftA + 5*ScanPhaseShiftB)
  Circ_Patch_5GHz_hex1_1:159: ScanMag1*1 ScanPhase1 + (13*ScanPhaseShiftA + 6*ScanPhaseShiftB)
  Circ_Patch_5GHz_hex1_1:160: ScanMag1*1 ScanPhase1 + (13*ScanPhaseShiftA + 7*ScanPhaseShiftB)
  Circ_Patch_5GHz_hex1_1:161: ScanMag1*1 ScanPhase1 + (13*ScanPhaseShiftA + 8*ScanPhaseShiftB)
  Circ_Patch_5GHz_hex1_1:162: ScanMag1*1 ScanPhase1 + (14*ScanPhaseShiftA + 0*ScanPhaseShiftB)
  Circ_Patch_5GHz_hex1_1:163: ScanMag1*1 ScanPhase1 + (14*ScanPhaseShiftA + 1*ScanPhaseShiftB)
  Circ_Patch_5GHz_hex1_1:164: ScanMag1*1 ScanPhase1 + (14*ScanPhaseShiftA + 2*ScanPhaseShiftB)
  Circ_Patch_5GHz_hex1_1:165: ScanMag1*1 ScanPhase1 + (14*ScanPhaseShiftA + 3*ScanPhaseShiftB)
  Circ_Patch_5GHz_hex1_1:166: ScanMag1*1 ScanPhase1 + (14*ScanPhaseShiftA + 4*ScanPhaseShiftB)
  Circ_Patch_5GHz_hex1_1:167: ScanMag1*1 ScanPhase1 + (14*ScanPhaseShiftA + 5*ScanPhaseShiftB)
  Circ_Patch_5GHz_hex1_1:168: ScanMag1*1 ScanPhase1 + (14*ScanPhaseShiftA + 6*ScanPhaseShiftB)
  Circ_Patch_5GHz_hex1_1:169: ScanMag1*1 ScanPhase1 + (14*ScanPhaseShiftA + 7*ScanPhaseShiftB)
radiation setups:
  Infinite Sphere1: Infinite Sphere Theta=0deg..180deg step 2deg Phi=-180deg..180deg step 2deg
reports:
  Gain Plot 1: dB(GainTotal) vs Phi, Theta on Setup1 : LastAdaptive, Infinite Sphere1 [Freq=5GHz]

design triangular_lattice_small (HFSS, DrivenModal, model units mm)
geometry:
  Circ_Patch_5GHz_hex1 = component(Circ_Patch_5GHz_hex, 3D_Component_File_Path="C:/Users/asligar/OneDrive - ANSYS, Inc/Documents/Applications/AGI Demo/Circ_Patch_5GHz_hex.a3dcomp", H=1.272mm, coax_inner_rad=0.25mm, Dp=23.53mm, Sx=35.29mm, Sy=35.29mm, Ln=1.502mm, Wn=3.004mm, beta3=-180deg, coax_outer_rad=0.85mm, feedLength=2.5mm, Sf=3.663mm, alpha=45deg)
  Circle_2 [vacuum] = part_of(Circ_Patch_5GHz_hex1)
  FeedPin_2, coax_pin_2 [pec] = part_of(Circ_Patch_5GHz_hex1)
  coax_2 [Teflon (tm)] = part_of(Circ_Patch_5GHz_hex1)
  Cylinder1 [vacuum] = part_of(Circ_Patch_5GHz_hex1)
  sub, sub_ObjectFromFace1 [Teflon (tm)] = part_of(Circ_Patch_5GHz_hex1)
  Circ_Patch_5GHz_hex1.move(TranslateVectorX=0.0615 TranslateVectorY=-0.017753521 TranslateVectorZ=0)
boundaries and excitations:
  Circ_Patch_5GHz_hex1_antennaMetal_2: Perfect E Objects=Circle_2
  Circ_Patch_5GHz_hex1_coax_outer_2: Perfect E Faces=coax_2.face(#48)
  Circ_Patch_5GHz_hex1_PerfE1: Perfect E Objects=sub_ObjectFromFace1
  Circ_Patch_5GHz_hex1_Rad1: Radiation Faces=Cylinder1.face(#56)
  Circ_Patch_5GHz_hex1_Primary1: Primary Faces=Cylinder1.face(#58) CoordSysVector{(71.75, -35.507042, -1.272) -> (71.75, -35.507042, 38.728)}
  Circ_Patch_5GHz_hex1_Secondary1: Secondary Faces=Cylinder1.face(#61) CoordSysVector{(41, -17.753521, -1.272) -> (41, -17.753521, 38.728)} ReverseV primary=Circ_Patch_5GHz_hex1_Primary1 PhaseDelay=UseScanAngle Phi=0deg Theta=0deg
  Circ_Patch_5GHz_hex1_Primary2: Primary Faces=Cylinder1.face(#63) CoordSysVector{(82, -17.753521, -1.272) -> (82, -17.753521, 38.728)}
  Circ_Patch_5GHz_hex1_Secondary2: Secondary Faces=Cylinder1.face(#60) CoordSysVector{(51.25, -35.507042, -1.272) -> (51.25, -35.507042, 38.728)} ReverseV primary=Circ_Patch_5GHz_hex1_Primary2 PhaseDelay=UseScanAngle Phi=0deg Theta=0deg
  Circ_Patch_5GHz_hex1_Primary3: Primary Faces=Cylinder1.face(#62) CoordSysVector{(71.75, 0, -1.272) -> (71.75, 0, 38.728)}
  Circ_Patch_5GHz_hex1_Secondary3: Secondary Faces=Cylinder1.face(#59) CoordSysVector{(71.75, -35.507042, -1.272) -> (71.75, -35.507042, 38.728)} ReverseV primary=Circ_Patch_5GHz_hex1_Primary3 PhaseDelay=UseScanAngle Phi=0deg Theta=0deg
  Circ_Patch_5GHz_hex1_1: Wave Port Faces=coax_2.face(#49) NumModes=1 Modes{Mode1{IntLine{(58.308827, -20.944694, -3.772) -> (58.733091, -20.52043, -3.772)} CharImp=Zpi}}
array:
  Type="3D Component" Name=A UseAirObjects RowPrimaryBnd=Circ_Patch_5GHz_hex1_Primary1 ColumnPrimaryBnd=Circ_Patch_5GHz_hex1_Primary2 RowDimension=4 ColumnDimension=4 RenderType=0 Padding=0 ComponentList(5)
  UseAbove
setups:
  Setup1: HfssDriven Frequency=5GHz MaxDeltaS=0.02 MaximumPasses=3 MinimumPasses=1 MinimumConvergedPasses=1 PercentRefinement=30 BasisOrder=1 PortAccuracy=2 DrivenSolverType="Direct Solver" SaveRadFieldsOnly InfiniteSphereSetup=1
source amplitudes:
  Circ_Patch_5GHz_hex1_1:1, Circ_Patch_5GHz_hex1_1:3..Circ_Patch_5GHz_hex1_1:14: 0W 0deg
  Circ_Patch_5GHz_hex1_1:2: 1W 0deg
radiation setups:
  Infinite Sphere1: Infinite Sphere Theta=0deg..180deg step 2deg Phi=-180deg..180deg step 2deg
