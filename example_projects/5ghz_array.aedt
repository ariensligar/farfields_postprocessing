# Ansys Electronics Desktop project, version 2022.1
materials:
  vacuum: permittivity=1

design rect_lattice (HFSS, DrivenModal, model units mm)
geometry:
  Circ_Patch_5GHz1 = component(Circ_Patch_5GHz, 3D_Component_File_Path="C:/Users/asligar/OneDrive - ANSYS, Inc/Documents/Applications/AGI Demo/Circ_Patch_5GHz.a3dcomp", H=1.272mm, coax_inner_rad=0.25mm, Dp=23.53mm, Sx=35.29mm, Sy=35.29mm, Ln=1.502mm, Wn=3.004mm, beta2=-90deg, beta3=-180deg, beta4=-270deg, coax_outer_rad=0.85mm, feedLength=2.5mm, Sf=3.663mm, alpha=45deg, subWidth=80mm, subLength=80mm)
  Soil [Teflon (tm)] = part_of(Circ_Patch_5GHz1)
  Ground, Circle_2 [vacuum] = part_of(Circ_Patch_5GHz1)
  FeedPin_2, coax_pin_2 [pec] = part_of(Circ_Patch_5GHz1)
  coax_2 [Teflon (tm)] = part_of(Circ_Patch_5GHz1)
  Box1 [vacuum] = part_of(Circ_Patch_5GHz1)
  Circ_Patch_5GHz1.move(TranslateVectorX=0.24703 TranslateVectorY=0.24703 TranslateVectorZ=0)
boundaries and excitations:
  Circ_Patch_5GHz1_antennaMetal_2: Perfect E Objects=Circle_2
  Circ_Patch_5GHz1_groundMetal: Perfect E Objects=Ground
  Circ_Patch_5GHz1_coax_outer_2: Perfect E Faces=coax_2.face(#87)
  Circ_Patch_5GHz1_Rad1: Radiation Faces=Box1.face(#95)
  Circ_Patch_5GHz1_Primary1: Primary Faces=Box1.face(#99) CoordSysVector{(264.675, 264.675, -1.272) -> (264.675, 264.675, 30)}
  Circ_Patch_5GHz1_Secondary1: Secondary Faces=Box1.face(#97) CoordSysVector{(264.675, 229.385, -1.272) -> (264.675, 229.385, 30)} ReverseV primary=Circ_Patch_5GHz1_Primary1 PhaseDelay=UseScanAngle Phi=0deg Theta=0deg
  Circ_Patch_5GHz1_Primary2: Primary Faces=Box1.face(#100) CoordSysVector{(264.675, 229.385, -1.272) -> (264.675, 229.385, 30)}
  Circ_Patch_5GHz1_Secondary2: Secondary Faces=Box1.face(#98) CoordSysVector{(229.385, 229.385, -1.272) -> (229.385, 229.385, 30)} ReverseV primary=Circ_Patch_5GHz1_Primary2 PhaseDelay=UseScanAngle Phi=0deg Theta=0deg
  Circ_Patch_5GHz1_1: Wave Port Faces=coax_2.face(#88) NumModes=1 Modes{Mode1{IntLine{(243.83883, 243.83883, -3.772) -> (244.26309, 244.26309, -3.772)} CharImp=Zpi}}
array:
  Type="3D Component" Name=A UseAirObjects RowPrimaryBnd=Circ_Patch_5GHz1_Primary1 ColumnPrimaryBnd=Circ_Patch_5GHz1_Primary2 RowDimension=15 ColumnDimension=15 RenderType=0 Padding=0 ComponentList(5)
  UseAbove
source amplitudes:
  Circ_Patch_5GHz1_1:1: 1W 0deg
  Circ_Patch_5GHz1_1:2..Circ_Patch_5GHz1_1:225: 0W 0deg

design triangular_lattice (HFSS, DrivenModal, model units mm)
geometry:
  Circ_Patch_5GHz_hex1 = component(Circ_Patch_5GHz_hex, 3D_Component_File_Path="C:/Users/asligar/OneDrive - ANSYS, Inc/Documents/Applications/AGI Demo/Circ_Patch_5GHz_hex.a3dcomp", H=1.272mm, coax_inner_rad=0.25mm, Dp=23.53mm, Sx=35.29mm, Sy=35.29mm, Ln=1.502mm, Wn=3.004mm, beta3=-180deg, coax_outer_rad=0.85mm, feedLength=2.5mm, Sf=3.663mm, alpha=45deg)
  Circle_2 [vacuum] = part_of(Circ_Patch_5GHz_hex1)
  FeedPin_2, coax_pin_2 [pec] = part_of(Circ_Patch_5GHz_hex1)
  coax_2 [Teflon (tm)] = part_of(Circ_Patch_5GHz_hex1)
  Cylinder1 [vacuum] = part_of(Circ_Patch_5GHz_hex1)
  sub, sub_ObjectFromFace1 [Teflon (tm)] = part_of(Circ_Patch_5GHz_hex1)
  Circ_Patch_5GHz_hex1.move(TranslateVectorX=0.21525 TranslateVectorY=-0.12427465 TranslateVectorZ=0)
boundaries and excitations:
  Circ_Patch_5GHz_hex1_antennaMetal_2: Perfect E Objects=Circle_2
  Circ_Patch_5GHz_hex1_coax_outer_2: Perfect E Faces=coax_2.face(#48)
  Circ_Patch_5GHz_hex1_PerfE1: Perfect E Objects=sub_ObjectFromFace1
  Circ_Patch_5GHz_hex1_Rad1: Radiation Faces=Cylinder1.face(#56)
  Circ_Patch_5GHz_hex1_Primary1: Primary Faces=Cylinder1.face(#58) CoordSysVector{(225.5, -142.02817, -1.272) -> (225.5, -142.02817, 38.728)}
  Circ_Patch_5GHz_hex1_Secondary1: Secondary Faces=Cylinder1.face(#61) CoordSysVector{(194.75, -124.27465, -1.272) -> (194.75, -124.27465, 38.728)} ReverseV primary=Circ_Patch_5GHz_hex1_Primary1 PhaseDelay=UseScanAngle Phi=0deg Theta=0deg
  Circ_Patch_5GHz_hex1_Primary2: Primary Faces=Cylinder1.face(#63) CoordSysVector{(235.75, -124.27465, -1.272) -> (235.75, -124.27465, 38.728)}
  Circ_Patch_5GHz_hex1_Secondary2: Secondary Faces=Cylinder1.face(#60) CoordSysVector{(205, -142.02817, -1.272) -> (205, -142.02817, 38.728)} ReverseV primary=Circ_Patch_5GHz_hex1_Primary2 PhaseDelay=UseScanAngle Phi=0deg Theta=0deg
  Circ_Patch_5GHz_hex1_Primary3: Primary Faces=Cylinder1.face(#62) CoordSysVector{(225.5, -106.52112, -1.272) -> (225.5, -106.52112, 38.728)}
  Circ_Patch_5GHz_hex1_Secondary3: Secondary Faces=Cylinder1.face(#59) CoordSysVector{(225.5, -142.02817, -1.272) -> (225.5, -142.02817, 38.728)} ReverseV primary=Circ_Patch_5GHz_hex1_Primary3 PhaseDelay=UseScanAngle Phi=0deg Theta=0deg
  Circ_Patch_5GHz_hex1_1: Wave Port Faces=coax_2.face(#49) NumModes=1 Modes{Mode1{IntLine{(212.05883, -127.46582, -3.772) -> (212.48309, -127.04155, -3.772)} CharImp=Zpi}}
array:
  Type="3D Component" Name=A UseAirObjects RowPrimaryBnd=Circ_Patch_5GHz_hex1_Primary1 ColumnPrimaryBnd=Circ_Patch_5GHz_hex1_Primary2 RowDimension=15 ColumnDimension=15 RenderType=0 Padding=0 ComponentList(5)
  UseAbove
setups:
  Setup1: HfssDriven Frequency=5GHz MaxDeltaS=0.02 MaximumPasses=3 MinimumPasses=1 MinimumConvergedPasses=1 PercentRefinement=30 BasisOrder=1 PortAccuracy=2 DrivenSolverType="Direct Solver" SaveRadFieldsOnly InfiniteSphereSetup=1
source amplitudes:
  Circ_Patch_5GHz_hex1_1:1: 1W 0deg
  Circ_Patch_5GHz_hex1_1:2..Circ_Patch_5GHz_hex1_1:169: 0W 0deg
radiation setups:
  Infinite Sphere1: Infinite Sphere Theta=0deg..180deg step 2deg Phi=-180deg..180deg step 2deg

design triangular_lattice_small (HFSS, DrivenModal, model units mm)
geometry:
  Circ_Patch_5GHz_hex1 = component(Circ_Patch_5GHz_hex, 3D_Component_File_Path="C:/Users/asligar/OneDrive - ANSYS, Inc/Documents/Applications/AGI Demo/Circ_Patch_5GHz_hex.a3dcomp", H=1.272mm, coax_inner_rad=0.25mm, Dp=23.53mm, Sx=35.29mm, Sy=35.29mm, Ln=1.502mm, Wn=3.004mm, beta3=-180deg, coax_outer_rad=0.85mm, feedLength=2.5mm, Sf=3.663mm, alpha=45deg)
  Circle_2 [vacuum] = part_of(Circ_Patch_5GHz_hex1)
  FeedPin_2, coax_pin_2 [pec] = part_of(Circ_Patch_5GHz_hex1)
  coax_2 [Teflon (tm)] = part_of(Circ_Patch_5GHz_hex1)
  Cylinder1 [vacuum] = part_of(Circ_Patch_5GHz_hex1)
  sub, sub_ObjectFromFace1 [Teflon (tm)] = part_of(Circ_Patch_5GHz_hex1)
  Circ_Patch_5GHz_hex1.move(TranslateVectorX=0.0615 TranslateVectorY=-0.017753521 TranslateVectorZ=0)
boundaries and excitations:
  Circ_Patch_5GHz_hex1_antennaMetal_2: Perfect E Objects=Circle_2
  Circ_Patch_5GHz_hex1_coax_outer_2: Perfect E Faces=coax_2.face(#48)
  Circ_Patch_5GHz_hex1_PerfE1: Perfect E Objects=sub_ObjectFromFace1
  Circ_Patch_5GHz_hex1_Rad1: Radiation Faces=Cylinder1.face(#56)
  Circ_Patch_5GHz_hex1_Primary1: Primary Faces=Cylinder1.face(#58) CoordSysVector{(71.75, -35.507042, -1.272) -> (71.75, -35.507042, 38.728)}
  Circ_Patch_5GHz_hex1_Secondary1: Secondary Faces=Cylinder1.face(#61) CoordSysVector{(41, -17.753521, -1.272) -> (41, -17.753521, 38.728)} ReverseV primary=Circ_Patch_5GHz_hex1_Primary1 PhaseDelay=UseScanAngle Phi=0deg Theta=0deg
  Circ_Patch_5GHz_hex1_Primary2: Primary Faces=Cylinder1.face(#63) CoordSysVector{(82, -17.753521, -1.272) -> (82, -17.753521, 38.728)}
  Circ_Patch_5GHz_hex1_Secondary2: Secondary Faces=Cylinder1.face(#60) CoordSysVector{(51.25, -35.507042, -1.272) -> (51.25, -35.507042, 38.728)} ReverseV primary=Circ_Patch_5GHz_hex1_Primary2 PhaseDelay=UseScanAngle Phi=0deg Theta=0deg
  Circ_Patch_5GHz_hex1_Primary3: Primary Faces=Cylinder1.face(#62) CoordSysVector{(71.75, 0, -1.272) -> (71.75, 0, 38.728)}
  Circ_Patch_5GHz_hex1_Secondary3: Secondary Faces=Cylinder1.face(#59) CoordSysVector{(71.75, -35.507042, -1.272) -> (71.75, -35.507042, 38.728)} ReverseV primary=Circ_Patch_5GHz_hex1_Primary3 PhaseDelay=UseScanAngle Phi=0deg Theta=0deg
  Circ_Patch_5GHz_hex1_1: Wave Port Faces=coax_2.face(#49) NumModes=1 Modes{Mode1{IntLine{(58.308827, -20.944694, -3.772) -> (58.733091, -20.52043, -3.772)} CharImp=Zpi}}
array:
  Type="3D Component" Name=A UseAirObjects RowPrimaryBnd=Circ_Patch_5GHz_hex1_Primary1 ColumnPrimaryBnd=Circ_Patch_5GHz_hex1_Primary2 RowDimension=4 ColumnDimension=4 RenderType=0 Padding=0 ComponentList(5)
  UseAbove
setups:
  Setup1: HfssDriven Frequency=5GHz MaxDeltaS=0.02 MaximumPasses=3 MinimumPasses=1 MinimumConvergedPasses=1 PercentRefinement=30 BasisOrder=1 PortAccuracy=2 DrivenSolverType="Direct Solver" SaveRadFieldsOnly InfiniteSphereSetup=1
source amplitudes:
  Circ_Patch_5GHz_hex1_1:1, Circ_Patch_5GHz_hex1_1:3..Circ_Patch_5GHz_hex1_1:14: 0W 0deg
  Circ_Patch_5GHz_hex1_1:2: 1W 0deg
radiation setups:
  Infinite Sphere1: Infinite Sphere Theta=0deg..180deg step 2deg Phi=-180deg..180deg step 2deg
